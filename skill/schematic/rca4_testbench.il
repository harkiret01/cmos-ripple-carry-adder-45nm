procedure(hrRCA_tb2()
  let((cv nets ins k)
    cv = hrOpenW("RCA4_tb" "schematic" "schematic")
    ins = list("A0" "A1" "A2" "A3" "B0" "B1" "B2" "B3" "C0")
    nets = list(list("vdd" "vdd") list("gnd" "gnd!") list("C4" "C4"))
    foreach(n ins nets = cons(list(n strcat("d" n)) nets))
    for(i 0 3 nets = cons(list(sprintf(nil "S%d" i) sprintf(nil "S%d" i)) nets))
    hrPlace(cv hrLib "RCA4" "DUT" 0 0 nets nil)
    k = 0
    foreach(n ins
      hrPlace(cv hrLib "INV" strcat("DRV" n) -13.0+3.5*mod(k 3) 3.0-2.5*(k/3)
        list(list("in_a" strcat("src" n)) list("out_a" strcat("d" n)) list("Vdd" "vdd") list("GND" "gnd!")) nil)
      k = k + 1)
    k = 0
    foreach(n list("S0" "S1" "S2" "S3" "C4")
      hrPlace(cv hrLib "INV_2X" strcat("LD" n) 4.0+3.5*mod(k 2) 3.0-2.5*(k/2)
        list(list("in_a" n) list("out_a" strcat(n "_ld")) list("Vdd" "vdd") list("GND" "gnd!")) nil)
      k = k + 1)
    hrPlace(cv "analogLib" "vdc" "VDD" -15.5 3.0 '(("PLUS" "vdd") ("MINUS" "gnd!")) list(list("vdc" "string" "1")))
    schCreateNoteLabel(cv -9.5:4.6 "Drivers: INV_1X on A0-A3, B0-B3, C0 (inputs from bit sources in rca_stim.scs)" "centerCenter" "R0" "stick" 0.2 "normalLabel")
    schCreateNoteLabel(cv 6.0:4.6 "Loads: INV_2X on S0-S3, C4" "centerCenter" "R0" "stick" 0.2 "normalLabel")
    schCreateNoteLabel(cv 0.8:-1.8 "DUT: RCA4" "centerCenter" "R0" "stick" 0.2 "normalLabel")
    schCreateNoteLabel(cv -15.5:2.0 "VDD 1V" "centerCenter" "R0" "stick" 0.16 "normalLabel")
    hrFinish(cv)))
hrRCA_tb2()
hrDump("RCA4_tb")
