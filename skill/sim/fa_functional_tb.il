; functional testbench for a full adder (all 8 input combos, Gray order), drivers INV_1X, loads INV_2X
procedure(hrFA_ftb(tb dut)
  let((cv)
    cv = hrOpenW(tb "schematic" "schematic")
    hrPlace(cv hrLib dut "DUT" 0 0 '(("A" "dA") ("B" "dB") ("Cin" "dC") ("S" "S") ("Cout" "Cout") ("vdd" "vdd") ("gnd" "gnd!")) nil)
    hrPlace(cv hrLib "INV" "DRVA" -6 4 '(("in_a" "srcA") ("out_a" "dA") ("Vdd" "vdd") ("GND" "gnd!")) nil)
    hrPlace(cv hrLib "INV" "DRVB" -6 1 '(("in_a" "srcB") ("out_a" "dB") ("Vdd" "vdd") ("GND" "gnd!")) nil)
    hrPlace(cv hrLib "INV" "DRVC" -6 -2 '(("in_a" "srcC") ("out_a" "dC") ("Vdd" "vdd") ("GND" "gnd!")) nil)
    hrPlace(cv hrLib "INV_2X" "LDS" 7 2 '(("in_a" "S") ("out_a" "S_ld") ("Vdd" "vdd") ("GND" "gnd!")) nil)
    hrPlace(cv hrLib "INV_2X" "LDC" 7 -1 '(("in_a" "Cout") ("out_a" "Cout_ld") ("Vdd" "vdd") ("GND" "gnd!")) nil)
    hrPlace(cv "analogLib" "vdc" "VDD" -12 3 '(("PLUS" "vdd") ("MINUS" "gnd!")) list(list("vdc" "string" "1")))
    hrPlace(cv "analogLib" "vpulse" "VA" -10 4 '(("PLUS" "srcA") ("MINUS" "gnd!"))
      list(list("v1" "string" "1") list("v2" "string" "0") list("td" "string" "4n") list("tr" "string" "10p")
           list("tf" "string" "10p") list("pw" "string" "4n") list("per" "string" "8n")))
    hrPlace(cv "analogLib" "vpulse" "VB" -10 1 '(("PLUS" "srcB") ("MINUS" "gnd!"))
      list(list("v1" "string" "1") list("v2" "string" "0") list("td" "string" "2n") list("tr" "string" "10p")
           list("tf" "string" "10p") list("pw" "string" "4n") list("per" "string" "8n")))
    hrPlace(cv "analogLib" "vpulse" "VC" -10 -2 '(("PLUS" "srcC") ("MINUS" "gnd!"))
      list(list("v1" "string" "1") list("v2" "string" "0") list("td" "string" "1n") list("tr" "string" "10p")
           list("tf" "string" "10p") list("pw" "string" "2n") list("per" "string" "4n")))
    hrFinish(cv)))

procedure(hrSimFAf(tb)
  simulator('spectre)
  design(hrLib tb "schematic")
  resultsDir(strcat(strcat(hrWork "/sim/") tb))
  modelFile(list(hrModel "mc"))
  analysis('tran ?stop "8.5n" ?errpreset "conservative")
  temp(27) save('all) run()
  selectResult('tran)
  for(k 0 7
    let((t0)
      t0 = k*1e-9 + 0.9e-9
      printf("FUNC %s slot%d: A=%d B=%d Cin=%d -> S=%d Cout=%d\n" tb k
        round(value(VT("/dA") t0)) round(value(VT("/dB") t0)) round(value(VT("/dC") t0))
        round(value(VT("/S") t0)) round(value(VT("/Cout") t0))))))

; delay screenshot for the DUT testbench results
procedure(hrFAd(resdir which title)
  let((c t1 t2 tin tout out)
    openResults(resdir) selectResult('tran)
    c = VT("/dC")
    t1 = cross(c 0.5 1 "rising")  t2 = cross(c 0.5 1 "falling")
    case(which
      ("CoutR" tin = t1 out = "Cout" tout = cross(clip(VT("/Cout") t1 4n) 0.5 1 "rising"))
      ("CoutF" tin = t2 out = "Cout" tout = cross(clip(VT("/Cout") t2 4n) 0.5 1 "falling"))
      ("SF"    tin = t1 out = "S"    tout = cross(clip(VT("/S") t1 4n) 0.5 1 "falling"))
      ("SR"    tin = t2 out = "S"    tout = cross(clip(VT("/S") t2 4n) 0.5 1 "rising")))
    hrDelay(resdir "dC" out tin tout title)))
printf("fashots loaded\n")
