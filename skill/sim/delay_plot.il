;; Plot one input/output pair zoomed on a single edge with 50% markers and the delay in the legend.
procedure(hrCloseAll()
  let((ws)
    ws = setof(w hiGetWindowList() w != hiGetCIWindow())
    while(ws errset(hiCloseWindow(car(ws))) ws = setof(w hiGetWindowList() w != hiGetCIWindow()))))
procedure(hrDelay(resdir sin sout tin tout title)
  let((w)
    hrCloseAll()
    openResults(resdir) selectResult('tran)
    w = newWindow()
    plot(VT(strcat("/" sin)) VT(strcat("/" sout))
      ?expr list(sprintf(nil "%s  (50%% at %.4f ns)" sin tin*1e9)
                 sprintf(nil "%s  (50%% at %.4f ns)   DELAY = %.2f ps" sout tout*1e9 (tout-tin)*1e12)))
    errset(xLimit(list(tin-30e-12 tout+40e-12)))
    errset(addTitle(sprintf(nil "%s: delay = %.2f ps" title (tout-tin)*1e12)))
    errset(awvPlaceYMarker(w 0.5)) errset(awvPlaceXMarker(w tin)) errset(awvPlaceXMarker(w tout))
    w))
