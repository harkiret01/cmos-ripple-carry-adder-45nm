; add readable notes and bigger wire labels to generated schematics
procedure(hrAnno(cell notes)
  let((cv)
    cv = dbOpenCellViewByType(hrLib cell "schematic" nil "a")
    foreach(s setof(x cv~>shapes x~>objType == "label" && x~>layerName == "text") dbDeleteObject(s))
    foreach(s setof(x cv~>shapes x~>objType == "label") s~>height = 0.09)
    foreach(n notes
      schCreateNoteLabel(cv car(n):cadr(n) caddr(n) "centerCenter" "R0" "stick" 0.16))
    errset(schCheck(cv))
    dbSave(cv)
    printf("ANNO %s done\n" cell)))
hrAnno("FA_P2Q1" '((1.0 0.9 "X1: XOR (A xor B)") (5.0 0.9 "X2: XOR -> S")
                  (5.0 -1.6 "Gate P = NAND2_2X (GP)") (5.0 -4.1 "NAND2_1X (GN)") (9.0 -2.6 "Gate Q = NAND2_1X (GQ) -> Cout")))
hrAnno("FA_b" '((1.0 0.9 "X1: XOR") (5.0 0.9 "X2: XOR -> S") (1.0 -2.1 "N1: NAND2_1X (A,B)") (1.0 -4.6 "N2: NAND2_1X (A,Cin)")
               (5.0 -3.1 "N3: NAND2_1X") (8.5 -3.1 "I1: INV_1X") (5.0 -6.1 "N4: NAND2_1X (B,Cin)") (12.0 -4.1 "N5: NAND2_1X -> Cout")))
hrAnno("RCA4" '((16.0 -1.5 "FA0 (bit 0)") (11.0 -1.5 "FA1 (bit 1)") (6.0 -1.5 "FA2 (bit 2)") (1.0 -1.5 "FA3 (bit 3)")))
foreach(tb '("FA_P2Q1_tb" "FA_P1Q2_tb" "FA_P2Q2_tb" "FA_b_tb")
  hrAnno(tb '((-5.0 4.3 "Drivers: INV_1X") (8.0 3.3 "Loads: INV_2X") (1.0 -1.8 "DUT"))))
foreach(tb '("FA_P2Q1_func_tb" "FA_b_func_tb")
  hrAnno(tb '((-5.0 5.3 "Drivers: INV_1X") (8.0 3.3 "Loads: INV_2X") (1.0 -1.8 "DUT"))))
hrAnno("RCA4_tb" '((-7.0 7.3 "Drivers: INV_1X (A0-A3, B0-B3, C0)") (11.0 7.3 "Loads: INV_2X (S0-S3, C4)") (1.0 -2.2 "DUT: RCA4")))
