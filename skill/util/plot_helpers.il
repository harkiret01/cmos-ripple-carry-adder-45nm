; ---- screenshot helpers ----
envSetVal("graphic" "stopLevel" 'int 32)
hrBox = list(0:60 1600:745)
procedure(hrCloseAll()
  let((ws)
    ws = setof(w hiGetWindowList() w != hiGetCIWindow())
    while(ws
      errset(hiCloseWindow(car(ws)))
      ws = setof(w hiGetWindowList() w != hiGetCIWindow()))))
procedure(hrOpen(cell view)
  let((w)
    hrCloseAll()
    w = geOpen(?lib hrLib ?cell cell ?view view ?mode "r")
    hiResizeWindow(w hrBox)
    hiZoomAbsoluteScale(w 0.92)
    hiRaiseWindow(w)
    w))
; plot waveforms in strip mode
procedure(hrPlot(resdir sigs x1 x2 title ymark xmarks)
  let((w)
    hrCloseAll()
    openResults(resdir)
    selectResult('tran)
    w = newWindow()
    foreach(s sigs plot(VT(strcat("/" s)) ?expr list(s)))
    errset(displayMode("strip"))
    when(x1 errset(xLimit(list(x1 x2))))
    errset(addTitle(title))
    when(ymark errset(awvPlaceYMarker(w ymark)))
    foreach(xm xmarks errset(awvPlaceXMarker(w xm)))
    hiResizeWindow(w hrBox)
    hiRaiseWindow(w)
    w))
printf("shots.il loaded\n")
