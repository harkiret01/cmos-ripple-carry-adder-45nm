; FA_P2Q1 layout: X1 xor, X2 xor, GP NAND_2X, GQ NAND_1X, GN NAND_1X in one row
let((cv tf m)
  cv = dbOpenCellViewByType(hrLib "FA_P2Q1" "layout" "maskLayout" "w")
  unless(cv cv = dbOpenCellViewByType(hrLib "FA_P2Q1" "layout" "maskLayout" "a"))
  foreach(x cv~>instances dbDeleteObject(x))
  foreach(x cv~>vias dbDeleteObject(x))
  foreach(x cv~>shapes dbDeleteObject(x))
  foreach(x cv~>terminals dbDeleteObject(x))
  tf = techGetTechFile(dbOpenCellViewByType(hrLib "xor" "layout" nil "r"))
  hrCV = cv  hrTF = tf
  procedure(lR(ly x1 y1 x2 y2) dbCreateRect(hrCV list(ly "drawing") list(x1:y1 x2:y2)))
  procedure(lV(nm x y o) dbCreateVia(hrCV techFindViaDefByName(hrTF nm) x:y o nil))
  procedure(lI(cell name x y)
    dbCreateInst(hrCV dbOpenCellViewByType(hrLib cell "layout" nil "r") name x:y "R0"))
  lI("xor" "X1" 0 0)
  lI("xor" "X2" 4.8 0)
  lI("NAND_2X" "GP" 9.685 -0.02)
  lI("NAND_1X" "GQ" 12.58 -0.01)
  lI("NAND_1X" "GN" 14.98 -0.01)
  dbCreateParamInstByMasterName(cv "gsclib045_tech" "cellTmpl" "layout" "TMPL1" 0.07:0.07 "R0" 1 list(list("width" "float" 9.6)))
  dbCreateParamInstByMasterName(cv "gsclib045_tech" "cellTmpl" "layout" "TMPL2" 12.47:0.07 "R0" 1 list(list("width" "float" 4.6)))
  foreach(b '((9.60 0.01 9.84 0.13) (9.60 1.72 9.84 1.84) (12.20 0.01 12.54 0.13) (12.20 1.72 12.54 1.84)) apply('lR cons("Metal1" b)))
  ; via2 directly on xor internal M2 tracks
  foreach(p '((0.70 0.785) (4.20 0.955) (5.50 0.785) (9.00 0.955)) lV("M3_M2" car(p) cadr(p) "R90"))
  ; M1 access: via1 at p, M2 pad, via2 offset +0.13
  foreach(p '((2.62 0.60 "R90") (7.42 0.60 "R90") (10.895 0.74 "R90") (11.985 0.89 "R90") (11.485 1.315 "R90")
              (14.03 0.81 "R90") (12.88 0.89 "R90") (14.62 0.74 "R0") (16.43 0.81 "R90") (15.28 0.89 "R90") (17.02 0.74 "R0"))
    let((x y)
      x = car(p) y = cadr(p)
      lV("M2_M1" x y caddr(p))
      lR("Metal2" x-0.065 y-0.04 x+0.195 y+0.04)
      lV("M3_M2" x+0.13 y "R90")))
  ; nets: list(trackY list((riserX accessY) ...)); trackY nil = no track
  hrNets = list(
    list("A"   0.25 '((0.70 0.785) (16.56 0.81)))
    list("B"   0.41 '((4.20 0.955) (15.41 0.89)))
    list("x1"  0.57 '((2.75 0.60) (5.50 0.785) (12.115 0.89)))
    list("Cin" 0.73 '((9.00 0.955) (11.025 0.74)))
    list("np"  0.73 '((11.615 1.315) (14.16 0.81)))
    list("nab" 0.89 '((13.01 0.89) (17.15 0.74)))
    list("S"   1.20 '((7.55 0.60)))
    list("Cout" 1.20 '((14.75 0.74))))
  foreach(n hrNets
    let((ty rs xs lo hi)
      ty = cadr(n) rs = caddr(n)
      xs = mapcar('car rs)
      foreach(r rs
        lo = min(cadr(r) ty) - 0.04  hi = max(cadr(r) ty) + 0.04
        when(hi - lo < 0.26 lo = (lo + hi) / 2 - 0.13 hi = lo + 0.26)
        lR("Metal3" car(r)-0.04 lo car(r)+0.04 hi)
        when(length(rs) > 1 lV("M4_M3" car(r) ty "R90")))
      when(length(rs) > 1
        lR("Metal4" apply('min xs)-0.065 ty-0.04 apply('max xs)+0.065 ty+0.04))))
  ; pins
  foreach(p '(("A" "input" "Metal3" 0.66 0.45 0.74 0.51) ("B" "input" "Metal3" 4.16 0.60 4.24 0.66)
              ("Cin" "input" "Metal3" 8.96 0.80 9.04 0.86) ("S" "output" "Metal3" 7.51 1.0 7.59 1.06)
              ("Cout" "output" "Metal3" 14.71 1.0 14.79 1.06) ("vdd" "inputOutput" "Metal1" 8.0 1.75 8.06 1.81)
              ("gnd" "inputOutput" "Metal1" 8.0 0.04 8.06 0.10))
    let((net f)
      net = dbMakeNet(cv car(p))
      dbCreateTerm(net car(p) cadr(p))
      f = apply('lR cdr(cdr(p)))
      dbCreatePin(net f)
      dbCreateLabel(cv list(caddr(p) "drawing") (nth(3 p)+nth(5 p))/2:(nth(4 p)+nth(6 p))/2 car(p) "centerCenter" "R0" "stick" 0.05)))
  dbSave(cv)
  printf("FA layout built: inst=%d vias=%d shapes=%d bbox=%L\n" length(cv~>instances) length(cv~>vias) length(cv~>shapes) cv~>bBox))
