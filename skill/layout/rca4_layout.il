; RCA4 layout: 4 FA_P2Q1 rows, alternate rows mirrored (MX) to share rails
let((cv tf rows)
  cv = dbOpenCellViewByType(hrLib "RCA4" "layout" "maskLayout" "w")
  unless(cv cv = dbOpenCellViewByType(hrLib "RCA4" "layout" "maskLayout" "a"))
  foreach(x cv~>instances dbDeleteObject(x))
  foreach(x cv~>vias dbDeleteObject(x))
  foreach(x cv~>shapes dbDeleteObject(x))
  foreach(x cv~>terminals dbDeleteObject(x))
  hrCV = cv
  hrTF = techGetTechFile(dbOpenCellViewByType(hrLib "xor" "layout" nil "r"))
  ; (name Y orient)
  rows = '(("FA0" 0.0 "R0") ("FA1" 3.56 "MX") ("FA2" 3.42 "R0") ("FA3" 6.98 "MX"))
  foreach(r rows
    dbCreateInst(cv dbOpenCellViewByType(hrLib "FA_P2Q1" "layout" nil "r") car(r) 0:cadr(r) caddr(r)))
  ; carry links: M3 up from Cout riser (x 14.75), M4 across at yc, M3 to next Cin riser (x 9.00)
  foreach(k '((1.20 1.64 1.60 1.56 2.60) (2.82 3.53 3.49 3.45 4.15) (4.62 5.06 5.02 4.98 6.02))
    let((a b yc c d)
      a = nth(0 k) b = nth(1 k) yc = nth(2 k) c = nth(3 k) d = nth(4 k)
      lR("Metal3" 14.71 a 14.79 b)
      lV("M4_M3" 14.75 yc "R90")
      lR("Metal4" 8.935 yc-0.04 14.815 yc+0.04)
      lV("M4_M3" 9.00 yc "R90")
      lR("Metal3" 8.96 c 9.04 d)))
  ; supply straps: gnd on the left, vdd on the right
  foreach(y '(0.01 3.43 6.85) lR("Metal1" -0.40 y 0.10 y+0.12))
  lR("Metal1" -0.40 0.01 -0.28 6.97)
  foreach(y '(1.72 5.14) lR("Metal1" 17.00 y 17.52 y+0.12))
  lR("Metal1" 17.40 1.72 17.52 5.26)
  ; pins
  hrPins = list(
    '("A0" "input" "Metal3" 0.66 0.45 0.74 0.51) '("B0" "input" "Metal3" 4.16 0.60 4.24 0.66) '("S0" "output" "Metal3" 7.51 1.00 7.59 1.06)
    '("A1" "input" "Metal3" 0.66 3.05 0.74 3.11) '("B1" "input" "Metal3" 4.16 2.90 4.24 2.96) '("S1" "output" "Metal3" 7.51 2.50 7.59 2.56)
    '("A2" "input" "Metal3" 0.66 3.87 0.74 3.93) '("B2" "input" "Metal3" 4.16 4.02 4.24 4.08) '("S2" "output" "Metal3" 7.51 4.42 7.59 4.48)
    '("A3" "input" "Metal3" 0.66 6.47 0.74 6.53) '("B3" "input" "Metal3" 4.16 6.32 4.24 6.38) '("S3" "output" "Metal3" 7.51 5.92 7.59 5.98)
    '("C0" "input" "Metal3" 8.96 0.80 9.04 0.86) '("C4" "output" "Metal3" 14.71 5.92 14.79 5.98)
    '("gnd" "inputOutput" "Metal1" -0.40 3.40 -0.28 3.52) '("vdd" "inputOutput" "Metal1" 17.40 3.40 17.52 3.52))
  foreach(p hrPins
    let((net f)
      net = dbMakeNet(cv car(p))
      dbCreateTerm(net car(p) cadr(p))
      f = apply('lR cdr(cdr(p)))
      dbCreatePin(net f)
      dbCreateLabel(cv list(caddr(p) "drawing") (nth(3 p)+nth(5 p))/2:(nth(4 p)+nth(6 p))/2 car(p) "centerCenter" "R0" "stick" 0.05)))
  dbSave(cv)
  printf("RCA layout built: inst=%d vias=%d shapes=%d bbox=%L\n" length(cv~>instances) length(cv~>vias) length(cv~>shapes) cv~>bBox))
